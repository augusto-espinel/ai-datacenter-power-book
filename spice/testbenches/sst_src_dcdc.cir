* ═══════════════════════════════════════════════════════════════
* SST SERIES RESONANT CONVERTER (SRC) — DC/DC STAGE TESTBENCH
* Chapter 4, §4.7 — Isolated DC/DC "DC Transformer"
*
* Topology: Series Resonant Converter (SRC LLC)
*   MV-side H-bridge → resonant tank (Lr, Cr) → MF transformer → LV-side rectifier
*
* Input: 7 kV DC (from AC/DC stage)
* Output: 400 V DC
* Transformer turns ratio: n = 52:6 ≈ 8.67:1
* Resonant frequency: ~50 kHz
*
* What this sim shows:
*   1. Resonant tank current (sinusoidal at resonance)
*   2. ZVS on MV-side switches (voltage zero before gate ON)
*   3. ZVS on LV-side switches (phase-shift aligned)
*   4. Output voltage regulation (quasi-fixed ratio at resonance)
*   5. Load step response (fixed-ratio behavior)
* ═══════════════════════════════════════════════════════════════

* --- Input DC Source ---
Vin 1 0 DC 7000

* --- MV-Side H-Bridge ---
* S1, S4: diagonal pair 1 (gate g1)
S1 1 2 10 0 SMODEL
S4 0 3 10 0 SMODEL
* S2, S3: diagonal pair 2 (gate g2)
S2 1 3 11 0 SMODEL
S3 0 2 11 0 SMODEL

.MODEL SMODEL VSWITCH Ron=0.05 Roff=1e7 Von=10 Voff=0

* Gate signals: 50 kHz, 50% duty, 300ns dead-time
* Diagonal 1
Vg1 10 0 PULSE(0 15 0 10n 10n 9.7u 20u)
* Diagonal 2 (complement with dead-time)
Vg2 11 0 PULSE(0 15 10u 10n 10n 9.7u 20u)

* --- Resonant Tank ---
* Leakage inductance (resonant inductor)
Lr 2 4 200u
* Resonant capacitor
Cr 4 5 50n
* Resonant frequency: f = 1/(2*pi*sqrt(Lr*Cr)) = 1/(2*pi*sqrt(200e-6*50e-9)) ≈ 50.3 kHz

* --- MF Transformer (ideal, turns ratio n=8.67:1) ---
* Primary: nodes 5-6
* Secondary: nodes 7-8
* Using ideal transformer model with inductor
Lp1 5 6 1m
Ls1 7 8 13.3u
K1 Lp1 Ls1 0.999

* --- LV-Side Rectifier (synchronous, H-bridge) ---
* D1, D4: diagonal pair 1
S5 7 9 12 0 SMODEL2
S8 8 0 12 0 SMODEL2
* D2, D3: diagonal pair 2
S6 7 0 13 0 SMODEL2
S7 8 9 13 0 SMODEL2

.MODEL SMODEL2 VSWITCH Ron=0.01 Roff=1e7 Von=10 Voff=0

* LV-side gates (phase-shifted by td=300ns for ZVS alignment)
Vg3 12 0 PULSE(0 15 300n 5n 5n 9.7u 20u)
Vg4 13 0 PULSE(0 15 10.3u 5n 5n 9.7u 20u)

* --- Output Filter ---
Cout 9 0 470u
Lout 9 14 10u

* --- Load ---
* 400V, 25kW → R = 400^2/25000 = 6.4 ohm
Rload 9 0 6.4

* --- Measurements ---
* Resonant tank current
.plot tran i(Lr)
* Primary voltage
.plot tran v(5)
* Secondary voltage
.plot tran v(7)
* Output voltage
.plot tran v(9)
* MV-side gate signals
.plot tran v(10) v(11)
* LV-side gate signals
.plot tran v(12) v(13)

* --- Transient Analysis ---
* 2ms covers ~100 switching cycles at 50kHz
.tran 20n 2m 0 20n

* --- Options ---
.options reltol=0.01 abstol=1e-6 vntol=0.1
.options method=gear

.end
